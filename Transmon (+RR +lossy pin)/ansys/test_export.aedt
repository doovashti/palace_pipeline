# Ansys Electronics Desktop project, version 2024.2
materials:
  vacuum: permittivity=1
  copper: permeability=0.999991 conductivity=58000000
  sapphire: permittivity=10
  perfect conductor: conductivity=1e+30
  diamond_pl_cvd: permittivity=3.5

design galvanic_no_WB (HFSS, Eigenmode, model units mm)
options: Allow_Material_Override
variables:
  rad = 4mm
  height = 35mm
  pin_rad = 1.5mm
  pin_heght = 17mm
  chip_offset = 1mm
  chip_wid = 4mm
  chip_len = 20mm
  chip_thick = 0.43mm
  pad_x = 1mm
  pad_y = 0.5mm
  pad_offset = 1mm
  coarse_x = 30um
  coarse_y = 50um
  medium_x = 10um
  medium_y = 30um
  thin_x = 1um
  thin_y = 25um
  jj_x = 1um
  jj_y = 1.9um
  L_JJ = 4nH
  wg_rad = 3mm
geometry:
  cavity [vacuum] = cylinder(axis=Z, base_centre=(0mm, 0mm, 0mm), radius=rad, height=height)
  pin [perfect conductor] = cylinder(axis=Z, base_centre=(0mm, 0mm, 0mm), radius=pin_rad, height=pin_heght)
  coordinate_system pin_end = origin=(0mm, pin_rad, pin_heght) x=(1mm, 0mm, 0mm) y=(0mm, 1mm, 0mm)
  chip [sapphire] = box(corner=(-chip_wid/2, chip_offset, -chip_thick), size=(chip_wid, chip_len, chip_thick)) in pin_end
  coordinate_system chip_begin = origin=(0mm, chip_offset, 0mm) x=(1mm, 0mm, 0mm) y=(0mm, 1mm, 0mm) in pin_end
  pads = rectangle(corner=(-pad_x/2, pad_offset, 0mm), x_size=pad_x, y_size=pad_y) in chip_begin
  coarse_lead = rectangle(corner=(-coarse_x/2, pad_offset+pad_y, 0mm), x_size=coarse_x, y_size=coarse_y) in chip_begin
  medium_lead = rectangle(corner=(-medium_x/2, pad_offset+pad_y+coarse_y, 0mm), x_size=medium_x, y_size=medium_y) in chip_begin
  thin_lead = rectangle(corner=(-thin_x/2, pad_offset+pad_y+coarse_y+medium_y, 0mm), x_size=thin_x, y_size=thin_y) in chip_begin
  coordinate_system JJ_CS = origin=(0mm, pad_offset+pad_y+coarse_y+medium_y+thin_y/2, 0mm) x=(1mm, 0mm, 0mm) y=(0mm, 1mm, 0mm) in chip_begin
  JJ = rectangle(corner=(-jj_x/2, -jj_y/2, 0mm), x_size=jj_x, y_size=jj_y) in JJ_CS
  JJ_1 = JJ.copy()
  thin_lead.subtract(JJ_1)
  left_pad_1 = pads.duplicate_mirror(point=(0mm, 0mm, 0mm), normal=(0mm, 1mm, 0mm)) in JJ_CS
  medium_lead_1 = medium_lead.duplicate_mirror(point=(0mm, 0mm, 0mm), normal=(0mm, 1mm, 0mm)) in JJ_CS
  coarse_lead_1 = coarse_lead.duplicate_mirror(point=(0mm, 0mm, 0mm), normal=(0mm, 1mm, 0mm)) in JJ_CS
  waveguide = cylinder(axis=Y, base_centre=(0mm, 0mm, 0mm), radius=wg_rad, height=chip_len) in chip_begin
  medium_lead.unite(medium_lead_1)
  coarse_lead.unite(coarse_lead_1)
  pads.unite(coarse_lead, left_pad_1)
  cavity.unite(waveguide)
  Plot_Fields [vacuum, non-model] = box(corner=(5mm, -10mm, 0mm), size=(-10mm, 30mm, 0mm)) in chip_begin
  Plot_Fields3D [vacuum, non-model] = box(corner=(5mm, -10mm, -5mm), size=(-10mm, 30mm, 10mm)) in chip_begin
boundaries and excitations:
  JJ_inductance: Lumped RLC Objects=JJ CurrentLine{(0, 4.09155, 17) -> (0, 4.09345, 17)} RLC_Type=Parallel Inductance=L_JJ Capacitance=3fF
  PerfE_Pads: Perfect E Objects=[thin_lead, pads, medium_lead]
mesh:
  JJ_mesh_0.2um: LengthBased Objects=JJ MaxLength=0.2um
  thin_lead_0.2um: LengthBased Objects=thin_lead MaxLength=0.2um
  medium_3um: LengthBased Objects=medium_lead MaxLength=3um
  pads_50um: LengthBased Objects=pads MaxLength=50um
  cav_pin1mm: LengthBased Objects=pin MaxLength=1mm
  initial mesh: GlobalCurvilinear{Apply} MeshMethod=AnsoftClassic
setups:
  Setup1: HfssEigen MinimumFrequency=1GHz NumModes=3 MaxDeltaFreq=10 ConvergeOnRealFreq=true MaximumPasses=4 MinimumPasses=3 MinimumConvergedPasses=1 PercentRefinement=30 BasisOrder=-1
source amplitudes:
  #-10:1: 1 0deg
  #-10:2: 0 0deg
  #-10:3: 0V_per_meter 0deg
optimetrics:
  ParametricSetup1: Parametric Sim._Setups=[Setup1]
    sweep L_JJ: LIN 2nH 20nH 2nH
field plots:
  Mag_E1, Mag_E2: E Field in Plot_Fields3D on Setup1 : LastAdaptive at Phase=0deg
reports:
  Eigen Modes Plot 1: re(Mode(1)), re(Mode(2)) vs L_JJ on Setup1 : LastAdaptive; markers m1 at 10nH, m2 at 10nH

design galvanic_one_WB (HFSS, Eigenmode, model units mm)
options: Allow_Material_Override
variables:
  rad = 4mm
  height = 35mm
  pin_rad = 1.5mm
  pin_heght = 17mm
  chip_offset = 1mm
  chip_wid = 4mm
  chip_len = 20mm
  chip_thick = 0.43mm
  pad_x = 1mm
  pad_y = 0.5mm
  pad_offset = 3mm
  coarse_x = 30um
  coarse_y = 50um
  medium_x = 10um
  medium_y = 30um
  thin_x = 1um
  thin_y = 25um
  jj_x = 1um
  jj_y = 1.9um
  L_JJ = 10nH
  wg_rad = 3mm
geometry:
  cavity [vacuum] = cylinder(axis=Z, base_centre=(0mm, 0mm, 0mm), radius=rad, height=height)
  pin [perfect conductor] = cylinder(axis=Z, base_centre=(0mm, 0mm, 0mm), radius=pin_rad, height=pin_heght)
  coordinate_system pin_end = origin=(0mm, pin_rad, pin_heght) x=(1mm, 0mm, 0mm) y=(0mm, 1mm, 0mm)
  chip [sapphire] = box(corner=(-chip_wid/2, chip_offset, -chip_thick), size=(chip_wid, chip_len, chip_thick)) in pin_end
  coordinate_system chip_begin = origin=(0mm, chip_offset, 0mm) x=(1mm, 0mm, 0mm) y=(0mm, 1mm, 0mm) in pin_end
  pads = rectangle(corner=(-pad_x/2, pad_offset, 0mm), x_size=pad_x, y_size=pad_y) in chip_begin
  coarse_lead = rectangle(corner=(-coarse_x/2, pad_offset+pad_y, 0mm), x_size=coarse_x, y_size=coarse_y) in chip_begin
  medium_lead = rectangle(corner=(-medium_x/2, pad_offset+pad_y+coarse_y, 0mm), x_size=medium_x, y_size=medium_y) in chip_begin
  thin_lead = rectangle(corner=(-thin_x/2, pad_offset+pad_y+coarse_y+medium_y, 0mm), x_size=thin_x, y_size=thin_y) in chip_begin
  coordinate_system JJ_CS = origin=(0mm, pad_offset+pad_y+coarse_y+medium_y+thin_y/2, 0mm) x=(1mm, 0mm, 0mm) y=(0mm, 1mm, 0mm) in chip_begin
  JJ = rectangle(corner=(-jj_x/2, -jj_y/2, 0mm), x_size=jj_x, y_size=jj_y) in JJ_CS
  JJ_1 = JJ.copy()
  thin_lead.subtract(JJ_1)
  left_pad_1 = pads.duplicate_mirror(point=(0mm, 0mm, 0mm), normal=(0mm, 1mm, 0mm)) in JJ_CS
  medium_lead_1 = medium_lead.duplicate_mirror(point=(0mm, 0mm, 0mm), normal=(0mm, 1mm, 0mm)) in JJ_CS
  coarse_lead_1 = coarse_lead.duplicate_mirror(point=(0mm, 0mm, 0mm), normal=(0mm, 1mm, 0mm)) in JJ_CS
  waveguide = cylinder(axis=Y, base_centre=(0mm, 0mm, 0mm), radius=wg_rad, height=chip_len) in chip_begin
  medium_lead.unite(medium_lead_1)
  coarse_lead.unite(coarse_lead_1)
  pads.unite(coarse_lead, left_pad_1)
  cavity.unite(waveguide)
  Plot_Fields2D [vacuum, non-model] = box(corner=(5mm, -10mm, 0mm), size=(-10mm, 30mm, 0mm)) in chip_begin
  Bondwire1 [perfect conductor] = bondwire(WireType=LOW WireDiameter=0.01mm NumSides=6 XPadPos=0mm YPadPos=-1.1mm ZPadPos=0mm XDir=0mm YDir=2.15mm ZDir=0mm Distance=pad_offset+chip_offset+0.15mm h1=0.2mm h2=0mm alpha=60deg beta=60deg WhichAxis=Z) in chip_begin
  Plot_Fields3D [vacuum, non-model] = box(corner=(5mm, -10mm, -5mm), size=(-10mm, 30mm, 10mm)) in chip_begin
boundaries and excitations:
  JJ_inductance: Lumped RLC Objects=JJ CurrentLine{(0, 6.09155, 17) -> (0, 6.09345, 17)} RLC_Type=Parallel Inductance=L_JJ Capacitance=3fF
  PerfE_Pads: Perfect E Objects=[thin_lead, pads, medium_lead]
mesh:
  JJ_mesh_0.2um: LengthBased Objects=JJ MaxLength=0.2um
  thin_lead_0.2um: LengthBased Objects=thin_lead MaxLength=0.2um
  medium_3um: LengthBased Objects=medium_lead MaxLength=3um
  pads_50um: LengthBased Objects=pads MaxLength=50um
  cav_pin1mm: LengthBased Objects=pin MaxLength=1mm
  initial mesh: GlobalCurvilinear{Apply} MeshMethod=AnsoftClassic
setups:
  Setup1: HfssEigen MinimumFrequency=1GHz NumModes=3 MaxDeltaFreq=10 ConvergeOnRealFreq=true MaximumPasses=4 MinimumPasses=3 MinimumConvergedPasses=1 PercentRefinement=30 BasisOrder=-1
source amplitudes:
  #-10:1: 0 0deg
  #-10:2: 1 0deg
  #-10:3: 0V_per_meter 0deg
optimetrics:
  ParametricSetup1: Parametric Sim._Setups=[Setup1]
    sweep L_JJ: LIN 2nH 20nH 2nH
field plots:
  Mag_E1: E Field in Plot_Fields3D on Setup1 : LastAdaptive at Phase=0deg
  Mesh1: MeshPlots over a plane on Setup1 : LastAdaptive at Phase=0deg
  Mesh2: MeshPlots in cavity on Setup1 : LastAdaptive at Phase=0deg
reports:
  Eigen Modes Plot 1: re(Mode(1)), re(Mode(2)) vs L_JJ on Setup1 : LastAdaptive; markers m1 at 10.917933nH, m2 at 10.917933nH

design galvanic_two_WB (HFSS, Eigenmode, model units mm)
options: Allow_Material_Override
variables:
  rad = 4mm
  height = 35mm
  pin_rad = 1.5mm
  pin_heght = 12mm
  chip_offset = 1mm
  chip_wid = 4mm
  chip_len = 20mm
  chip_thick = 0.43mm
  pad_x = 1mm
  pad_y = 0.5mm
  pad_offset = 4mm
  coarse_x = 30um
  coarse_y = 50um
  medium_x = 10um
  medium_y = 30um
  thin_x = 1um
  thin_y = 25um
  jj_x = 1um
  jj_y = 1.9um
  L_JJ = 20nH
  wg_rad = 3mm
geometry:
  cavity [vacuum] = cylinder(axis=Z, base_centre=(0mm, 0mm, 0mm), radius=rad, height=height)
  pin [perfect conductor] = cylinder(axis=Z, base_centre=(0mm, 0mm, 0mm), radius=pin_rad, height=pin_heght)
  coordinate_system pin_end = origin=(0mm, pin_rad, pin_heght) x=(1mm, 0mm, 0mm) y=(0mm, 1mm, 0mm)
  chip [sapphire] = box(corner=(-chip_wid/2, chip_offset, -chip_thick), size=(chip_wid, chip_len, chip_thick)) in pin_end
  coordinate_system chip_begin = origin=(0mm, chip_offset, 0mm) x=(1mm, 0mm, 0mm) y=(0mm, 1mm, 0mm) in pin_end
  pads = rectangle(corner=(-pad_x/2, pad_offset, 0mm), x_size=pad_x, y_size=pad_y) in chip_begin
  coarse_lead = rectangle(corner=(-coarse_x/2, pad_offset+pad_y, 0mm), x_size=coarse_x, y_size=coarse_y) in chip_begin
  medium_lead = rectangle(corner=(-medium_x/2, pad_offset+pad_y+coarse_y, 0mm), x_size=medium_x, y_size=medium_y) in chip_begin
  thin_lead = rectangle(corner=(-thin_x/2, pad_offset+pad_y+coarse_y+medium_y, 0mm), x_size=thin_x, y_size=thin_y) in chip_begin
  coordinate_system JJ_CS = origin=(0mm, pad_offset+pad_y+coarse_y+medium_y+thin_y/2, 0mm) x=(1mm, 0mm, 0mm) y=(0mm, 1mm, 0mm) in chip_begin
  JJ = rectangle(corner=(-jj_x/2, -jj_y/2, 0mm), x_size=jj_x, y_size=jj_y) in JJ_CS
  JJ_1 = JJ.copy()
  thin_lead.subtract(JJ_1)
  left_pad_1 = pads.duplicate_mirror(point=(0mm, 0mm, 0mm), normal=(0mm, 1mm, 0mm)) in JJ_CS
  medium_lead_1 = medium_lead.duplicate_mirror(point=(0mm, 0mm, 0mm), normal=(0mm, 1mm, 0mm)) in JJ_CS
  coarse_lead_1 = coarse_lead.duplicate_mirror(point=(0mm, 0mm, 0mm), normal=(0mm, 1mm, 0mm)) in JJ_CS
  waveguide = cylinder(axis=Y, base_centre=(0mm, 0mm, 0mm), radius=wg_rad, height=chip_len) in chip_begin
  medium_lead.unite(medium_lead_1)
  coarse_lead.unite(coarse_lead_1)
  pads.unite(coarse_lead, left_pad_1)
  cavity.unite(waveguide)
  Plot_Fields2D [vacuum, non-model] = box(corner=(5mm, -10mm, 0mm), size=(-10mm, 30mm, 0mm)) in chip_begin
  Plot_Fields3D [vacuum, non-model] = box(corner=(5mm, -10mm, -5mm), size=(-10mm, 30mm, 10mm)) in chip_begin
  Bondwire2 [perfect conductor] = bondwire(WireType=LOW WireDiameter=0.025mm NumSides=6 XPadPos=0.46mm YPadPos=chip_offset+pad_offset ZPadPos=0mm XDir=1mm YDir=0mm ZDir=0mm Distance=wg_rad-pad_x/2+0.1mm h1=0.2mm h2=0mm alpha=60deg beta=60deg WhichAxis=Z) in chip_begin
  Bondwire1 [perfect conductor] = bondwire(WireType=LOW WireDiameter=0.01mm NumSides=6 XPadPos=0mm YPadPos=-1.1mm ZPadPos=0mm XDir=0mm YDir=2.15mm ZDir=0mm Distance=pad_offset+chip_offset+0.15mm h1=0.2mm h2=0mm alpha=60deg beta=60deg WhichAxis=Z) in chip_begin
  jj_line [non-model] = polyline((0mm, -jj_y/2, 0mm) (0mm, jj_y/2, 0mm)) in JJ_CS
boundaries and excitations:
  JJ_inductance: Lumped RLC Objects=JJ CurrentLine{(0, 7.09155, 12) -> (0, 7.09345, 12)} RLC_Type=Parallel Inductance=L_JJ Capacitance=3fF
  PerfE_Pads: Perfect E Objects=[thin_lead, pads, medium_lead]
mesh:
  JJ_mesh_0.2um: LengthBased Objects=JJ MaxLength=0.2um
  thin_lead_0.2um: LengthBased Objects=thin_lead MaxLength=0.2um
  medium_3um: LengthBased Objects=medium_lead MaxLength=3um
  pads_50um: LengthBased Objects=pads MaxLength=50um
  cav_pin1mm: LengthBased Objects=pin MaxLength=1mm
  initial mesh: GlobalCurvilinear{Apply} MeshMethod=AnsoftClassic
setups:
  Setup1: HfssEigen MinimumFrequency=1GHz NumModes=3 MaxDeltaFreq=10 ConvergeOnRealFreq=true MaximumPasses=4 MinimumPasses=3 MinimumConvergedPasses=1 PercentRefinement=30 BasisOrder=-1
source amplitudes:
  #-10:1, #-10:2: 0 0deg
  #-10:3: 1 0deg
optimetrics:
  ParametricSetup1: Parametric Sim._Setups=[Setup1]
    sweep L_JJ: LIN 2nH 20nH 2nH
field plots:
  Mag_E1: E Field in Plot_Fields3D on Setup1 : LastAdaptive at Phase=0deg
reports:
  Eigen Modes Plot 1: re(Mode(1)), re(Mode(2)) vs L_JJ on Setup1 : LastAdaptive; markers m1 at 6nH, m2 at 6nH
  Freq. vs. pass: re(Mode(1)), re(Mode(2)), re(Mode(3)) vs Pass on Setup1 : AdaptivePass [chip_len=20mm chip_offset=1mm chip_thick=0.43mm chip_wid=4mm coarse_x=30um coarse_y=50um height=35mm jj_x=1um jj_y=1.9um L_JJ=20nH medium_x=10um medium_y=30um pad_offset=4mm pad_x=1mm pad_y=0.5mm pin_heght=12mm pin_rad=1.5mm rad=4mm thin_x=1um thin_y=25um wg_rad=3mm]

design galvanic_one_WB1 (HFSS, Eigenmode, model units mm)
options: Allow_Material_Override
variables:
  rad = 4mm
  height = 35mm
  pin_rad = 1.5mm
  pin_heght = 17mm
  chip_offset = 1mm
  chip_wid = 4mm
  chip_len = 20mm
  chip_thick = 0.43mm
  pad_x = 1mm
  pad_y = 0.5mm
  pad_offset = 3mm
  coarse_x = 30um
  coarse_y = 50um
  medium_x = 10um
  medium_y = 30um
  thin_x = 1um
  thin_y = 25um
  jj_x = 1um
  jj_y = 1.9um
  L_JJ = 10nH
  wg_rad = 3mm
geometry:
  coordinate_system pin_end = origin=(0mm, pin_rad, pin_heght) x=(1mm, 0mm, 0mm) y=(0mm, 1mm, 0mm)
  coordinate_system chip_begin = origin=(0mm, chip_offset, 0mm) x=(1mm, 0mm, 0mm) y=(0mm, 1mm, 0mm) in pin_end
  pads = rectangle(corner=(-pad_x/2, pad_offset, 0mm), x_size=pad_x, y_size=pad_y) in chip_begin
  coarse_lead = rectangle(corner=(-coarse_x/2, pad_offset+pad_y, 0mm), x_size=coarse_x, y_size=coarse_y) in chip_begin
  medium_lead = rectangle(corner=(-medium_x/2, pad_offset+pad_y+coarse_y, 0mm), x_size=medium_x, y_size=medium_y) in chip_begin
  thin_lead = rectangle(corner=(-thin_x/2, pad_offset+pad_y+coarse_y+medium_y, 0mm), x_size=thin_x, y_size=thin_y) in chip_begin
  coordinate_system JJ_CS = origin=(0mm, pad_offset+pad_y+coarse_y+medium_y+thin_y/2, 0mm) x=(1mm, 0mm, 0mm) y=(0mm, 1mm, 0mm) in chip_begin
  JJ = rectangle(corner=(-jj_x/2, -jj_y/2, 0mm), x_size=jj_x, y_size=jj_y) in JJ_CS
  JJ_1 = JJ.copy()
  thin_lead.subtract(JJ_1)
  left_pad_1 = pads.duplicate_mirror(point=(0mm, 0mm, 0mm), normal=(0mm, 1mm, 0mm)) in JJ_CS
  medium_lead_1 = medium_lead.duplicate_mirror(point=(0mm, 0mm, 0mm), normal=(0mm, 1mm, 0mm)) in JJ_CS
  coarse_lead_1 = coarse_lead.duplicate_mirror(point=(0mm, 0mm, 0mm), normal=(0mm, 1mm, 0mm)) in JJ_CS
  medium_lead.unite(medium_lead_1)
  coarse_lead.unite(coarse_lead_1)
  pads.unite(coarse_lead, left_pad_1)
  Plot_Fields2D [vacuum, non-model] = box(corner=(1mm, -1mm, -0.5mm), size=(-2mm, 2mm, 1mm)) in JJ_CS
boundaries and excitations:
  JJ_inductance: Lumped RLC Objects=JJ CurrentLine{(0, 6.09155, 17) -> (0, 6.09345, 17)} RLC_Type=Parallel Inductance=L_JJ Capacitance=3fF
  PerfE_Pads: Perfect E Objects=[thin_lead, pads, medium_lead]
mesh:
  JJ_mesh_0.2um: LengthBased Objects=JJ MaxLength=0.2um
  thin_lead_0.2um: LengthBased Objects=thin_lead MaxLength=0.2um
  medium_3um: LengthBased Objects=medium_lead MaxLength=3um
  pads_50um: LengthBased Objects=pads MaxLength=50um
  initial mesh: GlobalCurvilinear{Apply} MeshMethod=AnsoftClassic
setups:
  Setup1: HfssEigen MinimumFrequency=1GHz NumModes=3 MaxDeltaFreq=10 ConvergeOnRealFreq=true MaximumPasses=4 MinimumPasses=3 MinimumConvergedPasses=1 PercentRefinement=30 BasisOrder=-1
source amplitudes:
  #-10:1: 0 0deg
  #-10:2: 1 0deg
  #-10:3: 0V_per_meter 0deg
optimetrics:
  ParametricSetup1: Parametric Sim._Setups=[Setup1]
    sweep L_JJ: LIN 2nH 20nH 2nH
reports:
  Eigen Modes Plot 1: re(Mode(1)), re(Mode(2)) vs L_JJ on Setup1 : LastAdaptive; markers m1 at 10.917933nH, m2 at 10.917933nH

design galvanic_one_WB2 (HFSS, Eigenmode, model units mm)
options: Allow_Material_Override
variables:
  rad = 4mm
  height = 35mm
  pin_rad = 1.5mm
  pin_heght = 17mm
  chip_offset = 1mm
  chip_wid = 4mm
  chip_len = 20mm
  chip_thick = 0.43mm
  pad_x = 1mm
  pad_y = 0.5mm
  pad_offset = 3mm
  coarse_x = 30um
  coarse_y = 50um
  medium_x = 10um
  medium_y = 30um
  thin_x = 1um
  thin_y = 25um
  jj_x = 1um
  jj_y = 1.9um
  L_JJ = 10nH
  wg_rad = 3mm
geometry:
  coordinate_system pin_end = origin=(0mm, pin_rad, pin_heght) x=(1mm, 0mm, 0mm) y=(0mm, 1mm, 0mm)
  coordinate_system chip_begin = origin=(0mm, chip_offset, 0mm) x=(1mm, 0mm, 0mm) y=(0mm, 1mm, 0mm) in pin_end
  pads = rectangle(corner=(-pad_x/2, pad_offset, 0mm), x_size=pad_x, y_size=pad_y) in chip_begin
  coarse_lead = rectangle(corner=(-coarse_x/2, pad_offset+pad_y, 0mm), x_size=coarse_x, y_size=coarse_y) in chip_begin
  medium_lead = rectangle(corner=(-medium_x/2, pad_offset+pad_y+coarse_y, 0mm), x_size=medium_x, y_size=medium_y) in chip_begin
  thin_lead = rectangle(corner=(-thin_x/2, pad_offset+pad_y+coarse_y+medium_y, 0mm), x_size=thin_x, y_size=thin_y) in chip_begin
  coordinate_system JJ_CS = origin=(0mm, pad_offset+pad_y+coarse_y+medium_y+thin_y/2, 0mm) x=(1mm, 0mm, 0mm) y=(0mm, 1mm, 0mm) in chip_begin
  JJ = rectangle(corner=(-jj_x/2, -jj_y/2, 0mm), x_size=jj_x, y_size=jj_y) in JJ_CS
  JJ_1 = JJ.copy()
  thin_lead.subtract(JJ_1)
  left_pad_1 = pads.duplicate_mirror(point=(0mm, 0mm, 0mm), normal=(0mm, 1mm, 0mm)) in JJ_CS
  medium_lead_1 = medium_lead.duplicate_mirror(point=(0mm, 0mm, 0mm), normal=(0mm, 1mm, 0mm)) in JJ_CS
  coarse_lead_1 = coarse_lead.duplicate_mirror(point=(0mm, 0mm, 0mm), normal=(0mm, 1mm, 0mm)) in JJ_CS
  medium_lead.unite(medium_lead_1)
  coarse_lead.unite(coarse_lead_1)
  pads.unite(coarse_lead, left_pad_1)
boundaries and excitations:
  JJ_inductance: Lumped RLC Objects=JJ CurrentLine{(0, 6.09155, 17) -> (0, 6.09345, 17)} RLC_Type=Parallel Inductance=L_JJ Capacitance=3fF
  PerfE_Pads: Perfect E Objects=[thin_lead, pads, medium_lead]
mesh:
  JJ_mesh_0.2um: LengthBased Objects=JJ MaxLength=0.2um
  thin_lead_0.2um: LengthBased Objects=thin_lead MaxLength=0.2um
  medium_3um: LengthBased Objects=medium_lead MaxLength=3um
  pads_50um: LengthBased Objects=pads MaxLength=50um
  initial mesh: GlobalCurvilinear{Apply} MeshMethod=AnsoftClassic
setups:
  Setup1: HfssEigen MinimumFrequency=1GHz NumModes=3 MaxDeltaFreq=10 ConvergeOnRealFreq=true MaximumPasses=4 MinimumPasses=3 MinimumConvergedPasses=1 PercentRefinement=30 BasisOrder=-1
source amplitudes:
  #-10:1: 0 0deg
  #-10:2: 1 0deg
  #-10:3: 0V_per_meter 0deg
optimetrics:
  ParametricSetup1: Parametric Sim._Setups=[Setup1]
    sweep L_JJ: LIN 2nH 20nH 2nH
reports:
  Eigen Modes Plot 1: re(Mode(1)), re(Mode(2)) vs L_JJ on Setup1 : LastAdaptive; markers m1 at 10.917933nH, m2 at 10.917933nH

design galvanic_one_WB3 (HFSS, Eigenmode, model units mm)
options: Allow_Material_Override
variables:
  rad = 4mm
  height = 35mm
  pin_rad = 1.5mm
  pin_heght = 17mm
  chip_offset = 1mm
  chip_wid = 4mm
  chip_len = 20mm
  chip_thick = 0.43mm
  pad_x = 1mm
  pad_y = 0.5mm
  pad_offset = 3mm
  coarse_x = 30um
  coarse_y = 50um
  medium_x = 10um
  medium_y = 30um
  thin_x = 1um
  thin_y = 25um
  jj_x = 1um
  jj_y = 1.9um
  L_JJ = 10nH
  wg_rad = 3mm
geometry:
  cavity [vacuum] = cylinder(axis=Z, base_centre=(0mm, 0mm, 0mm), radius=rad, height=height)
  pin [perfect conductor] = cylinder(axis=Z, base_centre=(0mm, 0mm, 0mm), radius=pin_rad, height=pin_heght)
  coordinate_system pin_end = origin=(0mm, pin_rad, pin_heght) x=(1mm, 0mm, 0mm) y=(0mm, 1mm, 0mm)
  chip [sapphire] = box(corner=(-chip_wid/2, chip_offset, -chip_thick), size=(chip_wid, chip_len, chip_thick)) in pin_end
  coordinate_system chip_begin = origin=(0mm, chip_offset, 0mm) x=(1mm, 0mm, 0mm) y=(0mm, 1mm, 0mm) in pin_end
  coordinate_system JJ_CS = origin=(0mm, pad_offset+pad_y+coarse_y+medium_y+thin_y/2, 0mm) x=(1mm, 0mm, 0mm) y=(0mm, 1mm, 0mm) in chip_begin
  waveguide = cylinder(axis=Y, base_centre=(0mm, 0mm, 0mm), radius=wg_rad, height=chip_len) in chip_begin
  cavity.unite(waveguide)
  Bondwire1 [perfect conductor] = bondwire(WireType=LOW WireDiameter=0.01mm NumSides=6 XPadPos=0mm YPadPos=-1.1mm ZPadPos=0mm XDir=0mm YDir=2.15mm ZDir=0mm Distance=pad_offset+chip_offset+0.15mm h1=0.2mm h2=0mm alpha=60deg beta=60deg WhichAxis=Z) in chip_begin
mesh:
  cav_pin1mm: LengthBased Objects=pin MaxLength=1mm
  initial mesh: GlobalCurvilinear{Apply} MeshMethod=AnsoftClassic
setups:
  Setup1: HfssEigen MinimumFrequency=1GHz NumModes=3 MaxDeltaFreq=10 ConvergeOnRealFreq=true MaximumPasses=4 MinimumPasses=3 MinimumConvergedPasses=1 PercentRefinement=30 BasisOrder=-1
source amplitudes:
  #-10:1: 0 0deg
  #-10:2: 1 0deg
  #-10:3: 0V_per_meter 0deg
optimetrics:
  ParametricSetup1: Parametric Sim._Setups=[Setup1]
    sweep L_JJ: LIN 2nH 20nH 2nH
reports:
  Eigen Modes Plot 1: re(Mode(1)), re(Mode(2)) vs L_JJ on Setup1 : LastAdaptive; markers m1 at 10.917933nH, m2 at 10.917933nH

design 00_cavity (HFSS, Eigenmode, model units mm)
options: Allow_Material_Override
variables:
  rad = 4mm
  height = 35mm
  pin_rad = 1.5mm
  pin_heght = 17mm
  chip_offset = 1mm
  chip_wid = 4mm
  chip_len = 20mm
  chip_thick = 0.43mm
  pad_x = 1mm
  pad_y = 0.5mm
  pad_offset = 3mm
  coarse_x = 30um
  coarse_y = 50um
  medium_x = 10um
  medium_y = 30um
  thin_x = 1um
  thin_y = 25um
  jj_x = 1um
  jj_y = 1.9um
  L_JJ = 10nH
  wg_rad = 3mm
geometry:
  cavity [vacuum] = cylinder(axis=Z, base_centre=(0mm, 0mm, 0mm), radius=rad, height=height)
  pin [perfect conductor] = cylinder(axis=Z, base_centre=(0mm, 0mm, 0mm), radius=pin_rad, height=pin_heght)
  coordinate_system pin_end = origin=(0mm, pin_rad, pin_heght) x=(1mm, 0mm, 0mm) y=(0mm, 1mm, 0mm)
  coordinate_system chip_begin = origin=(0mm, chip_offset, 0mm) x=(1mm, 0mm, 0mm) y=(0mm, 1mm, 0mm) in pin_end
  coordinate_system JJ_CS = origin=(0mm, pad_offset+pad_y+coarse_y+medium_y+thin_y/2, 0mm) x=(1mm, 0mm, 0mm) y=(0mm, 1mm, 0mm) in chip_begin
  waveguide = cylinder(axis=Y, base_centre=(0mm, 0mm, 0mm), radius=wg_rad, height=chip_len) in chip_begin
  cavity.unite(waveguide)
mesh:
  cav_pin1mm: LengthBased Objects=pin MaxLength=1mm
  initial mesh: GlobalCurvilinear{Apply} MeshMethod=AnsoftClassic
setups:
  Setup1: HfssEigen MinimumFrequency=1GHz NumModes=3 MaxDeltaFreq=10 ConvergeOnRealFreq=true MaximumPasses=4 MinimumPasses=3 MinimumConvergedPasses=1 PercentRefinement=30 BasisOrder=-1
source amplitudes:
  #-10:1: 0 0deg
  #-10:2: 1 0deg
  #-10:3: 0V_per_meter 0deg
optimetrics:
  ParametricSetup1: Parametric Sim._Setups=[Setup1]
    sweep L_JJ: LIN 2nH 20nH 2nH
field plots:
  Mesh2: MeshPlots in cavity on Setup1 : LastAdaptive at Phase=0deg
reports:
  Eigen Modes Plot 1: re(Mode(1)), re(Mode(2)) vs L_JJ on Setup1 : LastAdaptive; markers m1 at 10.917933nH, m2 at 10.917933nH

design 01_00_p_chip (HFSS, Eigenmode, model units mm)
options: Allow_Material_Override
variables:
  rad = 4mm
  height = 35mm
  pin_rad = 1.5mm
  pin_heght = 17mm
  chip_offset = 1mm
  chip_wid = 4mm
  chip_len = 20mm
  chip_thick = 0.43mm
  pad_x = 1mm
  pad_y = 0.5mm
  pad_offset = 3mm
  coarse_x = 30um
  coarse_y = 50um
  medium_x = 10um
  medium_y = 30um
  thin_x = 1um
  thin_y = 25um
  jj_x = 1um
  jj_y = 1.9um
  L_JJ = 10nH
  wg_rad = 3mm
geometry:
  cavity [vacuum] = cylinder(axis=Z, base_centre=(0mm, 0mm, 0mm), radius=rad, height=height)
  pin [perfect conductor] = cylinder(axis=Z, base_centre=(0mm, 0mm, 0mm), radius=pin_rad, height=pin_heght)
  coordinate_system pin_end = origin=(0mm, pin_rad, pin_heght) x=(1mm, 0mm, 0mm) y=(0mm, 1mm, 0mm)
  chip [sapphire] = box(corner=(-chip_wid/2, chip_offset, -chip_thick), size=(chip_wid, chip_len, chip_thick)) in pin_end
  coordinate_system chip_begin = origin=(0mm, chip_offset, 0mm) x=(1mm, 0mm, 0mm) y=(0mm, 1mm, 0mm) in pin_end
  coordinate_system JJ_CS = origin=(0mm, pad_offset+pad_y+coarse_y+medium_y+thin_y/2, 0mm) x=(1mm, 0mm, 0mm) y=(0mm, 1mm, 0mm) in chip_begin
  waveguide = cylinder(axis=Y, base_centre=(0mm, 0mm, 0mm), radius=wg_rad, height=chip_len) in chip_begin
  cavity.unite(waveguide)
mesh:
  cav_pin1mm: LengthBased Objects=pin MaxLength=1mm
  initial mesh: GlobalCurvilinear{Apply} MeshMethod=AnsoftClassic
setups:
  Setup1: HfssEigen MinimumFrequency=1GHz NumModes=3 MaxDeltaFreq=3 ConvergeOnRealFreq=true MaximumPasses=4 MinimumPasses=4 MinimumConvergedPasses=2 PercentRefinement=30 BasisOrder=-1
source amplitudes:
  #-10:1: 0 0deg
  #-10:2: 1 0deg
  #-10:3: 0V_per_meter 0deg
optimetrics:
  ParametricSetup1: Parametric Sim._Setups=[Setup1]
    sweep L_JJ: LIN 2nH 20nH 2nH
field plots:
  Mesh2: MeshPlots in cavity on Setup1 : LastAdaptive at Phase=0deg
reports:
  Eigen Modes Plot 1: re(Mode(1)), re(Mode(2)) vs L_JJ on Setup1 : LastAdaptive; markers m1 at 10.917933nH, m2 at 10.917933nH

design 03_cav_pin_transmon (HFSS, Eigenmode, model units mm)
options: Allow_Material_Override
variables:
  rad = 4mm
  height = 35mm
  pin_rad = 1.5mm
  pin_heght = 17mm
  chip_offset = 1mm
  chip_wid = 4mm
  chip_len = 20mm
  chip_thick = 0.43mm
  pad_x = 1mm
  pad_y = 0.5mm
  pad_offset = 3mm
  coarse_x = 30um
  coarse_y = 50um
  medium_x = 10um
  medium_y = 30um
  thin_x = 1um
  thin_y = 25um
  jj_x = 1um
  jj_y = 1.9um
  L_JJ = 10nH
  wg_rad = 3mm
geometry:
  cavity [vacuum] = cylinder(axis=Z, base_centre=(0mm, 0mm, 0mm), radius=rad, height=height)
  pin [perfect conductor] = cylinder(axis=Z, base_centre=(0mm, 0mm, 0mm), radius=pin_rad, height=pin_heght)
  coordinate_system pin_end = origin=(0mm, pin_rad, pin_heght) x=(1mm, 0mm, 0mm) y=(0mm, 1mm, 0mm)
  chip [sapphire] = box(corner=(-chip_wid/2, chip_offset, -chip_thick), size=(chip_wid, chip_len, chip_thick)) in pin_end
  coordinate_system chip_begin = origin=(0mm, chip_offset, 0mm) x=(1mm, 0mm, 0mm) y=(0mm, 1mm, 0mm) in pin_end
  pads = rectangle(corner=(-pad_x/2, pad_offset, 0mm), x_size=pad_x, y_size=pad_y) in chip_begin
  coarse_lead = rectangle(corner=(-coarse_x/2, pad_offset+pad_y, 0mm), x_size=coarse_x, y_size=coarse_y) in chip_begin
  medium_lead = rectangle(corner=(-medium_x/2, pad_offset+pad_y+coarse_y, 0mm), x_size=medium_x, y_size=medium_y) in chip_begin
  thin_lead = rectangle(corner=(-thin_x/2, pad_offset+pad_y+coarse_y+medium_y, 0mm), x_size=thin_x, y_size=thin_y) in chip_begin
  coordinate_system JJ_CS = origin=(0mm, pad_offset+pad_y+coarse_y+medium_y+thin_y/2, 0mm) x=(1mm, 0mm, 0mm) y=(0mm, 1mm, 0mm) in chip_begin
  JJ = rectangle(corner=(-jj_x/2, -jj_y/2, 0mm), x_size=jj_x, y_size=jj_y) in JJ_CS
  JJ_1 = JJ.copy()
  thin_lead.subtract(JJ_1)
  left_pad_1 = pads.duplicate_mirror(point=(0mm, 0mm, 0mm), normal=(0mm, 1mm, 0mm)) in JJ_CS
  medium_lead_1 = medium_lead.duplicate_mirror(point=(0mm, 0mm, 0mm), normal=(0mm, 1mm, 0mm)) in JJ_CS
  coarse_lead_1 = coarse_lead.duplicate_mirror(point=(0mm, 0mm, 0mm), normal=(0mm, 1mm, 0mm)) in JJ_CS
  waveguide = cylinder(axis=Y, base_centre=(0mm, 0mm, 0mm), radius=wg_rad, height=chip_len) in chip_begin
  medium_lead.unite(medium_lead_1)
  coarse_lead.unite(coarse_lead_1)
  pads.unite(coarse_lead, left_pad_1)
  cavity.unite(waveguide)
boundaries and excitations:
  JJ_inductance: Lumped RLC Objects=JJ CurrentLine{(0, 6.09155, 17) -> (0, 6.09345, 17)} RLC_Type=Parallel Inductance=L_JJ Capacitance=3fF
  PerfE_Pads: Perfect E Objects=[thin_lead, pads, medium_lead]
mesh:
  JJ_mesh_0.2um: LengthBased Objects=JJ MaxLength=0.2um
  thin_lead_0.2um: LengthBased Objects=thin_lead MaxLength=0.2um
  medium_3um: LengthBased Objects=medium_lead MaxLength=3um
  pads_50um: LengthBased Objects=pads MaxLength=50um
  cav_pin1mm: LengthBased Objects=pin MaxLength=1mm
  initial mesh: GlobalCurvilinear{Apply} MeshMethod=AnsoftClassic
setups:
  Setup1: HfssEigen MinimumFrequency=1GHz NumModes=3 MaxDeltaFreq=10 ConvergeOnRealFreq=true MaximumPasses=4 MinimumPasses=3 MinimumConvergedPasses=1 PercentRefinement=30 BasisOrder=-1
source amplitudes:
  #-10:1: 0 0deg
  #-10:2: 1 0deg
  #-10:3: 0V_per_meter 0deg
optimetrics:
  ParametricSetup1: Parametric Sim._Setups=[Setup1]
    sweep L_JJ: LIN 2nH 20nH 2nH
field plots:
  Mesh2: MeshPlots in cavity on Setup1 : LastAdaptive at Phase=0deg
reports:
  Eigen Modes Plot 1: re(Mode(1)), re(Mode(2)) vs L_JJ on Setup1 : LastAdaptive; markers m1 at 10.917933nH, m2 at 10.917933nH

design galvanic_one_no_nonmodel_no_wire (HFSS, Eigenmode, model units mm)
options: Allow_Material_Override
variables:
  rad = 4mm
  height = 35mm
  pin_rad = 1.5mm
  pin_heght = 17mm
  chip_offset = 1mm
  chip_wid = 4mm
  chip_len = 20mm
  chip_thick = 0.43mm
  pad_x = 1mm
  pad_y = 0.5mm
  pad_offset = 3mm
  coarse_x = 30um
  coarse_y = 50um
  medium_x = 10um
  medium_y = 30um
  thin_x = 1um
  thin_y = 25um
  jj_x = 1um
  jj_y = 1.9um
  L_JJ = 10nH
  wg_rad = 3mm
geometry:
  cavity [vacuum] = cylinder(axis=Z, base_centre=(0mm, 0mm, 0mm), radius=rad, height=height)
  pin [perfect conductor] = cylinder(axis=Z, base_centre=(0mm, 0mm, 0mm), radius=pin_rad, height=pin_heght)
  coordinate_system pin_end = origin=(0mm, pin_rad, pin_heght) x=(1mm, 0mm, 0mm) y=(0mm, 1mm, 0mm)
  chip [sapphire] = box(corner=(-chip_wid/2, chip_offset, -chip_thick), size=(chip_wid, chip_len, chip_thick)) in pin_end
  coordinate_system chip_begin = origin=(0mm, chip_offset, 0mm) x=(1mm, 0mm, 0mm) y=(0mm, 1mm, 0mm) in pin_end
  pads = rectangle(corner=(-pad_x/2, pad_offset, 0mm), x_size=pad_x, y_size=pad_y) in chip_begin
  coarse_lead = rectangle(corner=(-coarse_x/2, pad_offset+pad_y, 0mm), x_size=coarse_x, y_size=coarse_y) in chip_begin
  medium_lead = rectangle(corner=(-medium_x/2, pad_offset+pad_y+coarse_y, 0mm), x_size=medium_x, y_size=medium_y) in chip_begin
  thin_lead = rectangle(corner=(-thin_x/2, pad_offset+pad_y+coarse_y+medium_y, 0mm), x_size=thin_x, y_size=thin_y) in chip_begin
  coordinate_system JJ_CS = origin=(0mm, pad_offset+pad_y+coarse_y+medium_y+thin_y/2, 0mm) x=(1mm, 0mm, 0mm) y=(0mm, 1mm, 0mm) in chip_begin
  JJ = rectangle(corner=(-jj_x/2, -jj_y/2, 0mm), x_size=jj_x, y_size=jj_y) in JJ_CS
  JJ_1 = JJ.copy()
  thin_lead.subtract(JJ_1)
  left_pad_1 = pads.duplicate_mirror(point=(0mm, 0mm, 0mm), normal=(0mm, 1mm, 0mm)) in JJ_CS
  medium_lead_1 = medium_lead.duplicate_mirror(point=(0mm, 0mm, 0mm), normal=(0mm, 1mm, 0mm)) in JJ_CS
  coarse_lead_1 = coarse_lead.duplicate_mirror(point=(0mm, 0mm, 0mm), normal=(0mm, 1mm, 0mm)) in JJ_CS
  waveguide = cylinder(axis=Y, base_centre=(0mm, 0mm, 0mm), radius=wg_rad, height=chip_len) in chip_begin
  medium_lead.unite(medium_lead_1)
  coarse_lead.unite(coarse_lead_1)
  pads.unite(coarse_lead, left_pad_1)
  cavity.unite(waveguide)
boundaries and excitations:
  JJ_inductance: Lumped RLC Objects=JJ CurrentLine{(0, 6.09155, 17) -> (0, 6.09345, 17)} RLC_Type=Parallel Inductance=L_JJ Capacitance=3fF
  PerfE_Pads: Perfect E Objects=[thin_lead, pads, medium_lead]
mesh:
  JJ_mesh_0.2um: LengthBased Objects=JJ MaxLength=0.2um
  thin_lead_0.2um: LengthBased Objects=thin_lead MaxLength=0.2um
  medium_3um: LengthBased Objects=medium_lead MaxLength=3um
  pads_50um: LengthBased Objects=pads MaxLength=50um
  cav_pin1mm: LengthBased Objects=pin MaxLength=1mm
  initial mesh: GlobalCurvilinear{Apply} MeshMethod=AnsoftClassic
setups:
  Setup1: HfssEigen MinimumFrequency=1GHz NumModes=3 MaxDeltaFreq=10 ConvergeOnRealFreq=true MaximumPasses=4 MinimumPasses=3 MinimumConvergedPasses=1 PercentRefinement=30 BasisOrder=-1
source amplitudes:
  #-10:1: 0 0deg
  #-10:2: 1 0deg
  #-10:3: 0V_per_meter 0deg
optimetrics:
  ParametricSetup1: Parametric Sim._Setups=[Setup1]
    sweep L_JJ: LIN 2nH 20nH 2nH
field plots:
  Mesh2: MeshPlots in cavity on Setup1 : LastAdaptive at Phase=0deg
reports:
  Eigen Modes Plot 1: re(Mode(1)), re(Mode(2)) vs L_JJ on Setup1 : LastAdaptive; markers m1 at 10.917933nH, m2 at 10.917933nH

design no_non_model (HFSS, Eigenmode, model units mm)
options: Allow_Material_Override
variables:
  rad = 4mm
  height = 35mm
  pin_rad = 1.5mm
  pin_heght = 17mm
  chip_offset = 1mm
  chip_wid = 4mm
  chip_len = 20mm
  chip_thick = 0.43mm
  pad_x = 1mm
  pad_y = 0.5mm
  pad_offset = 3mm
  coarse_x = 30um
  coarse_y = 50um
  medium_x = 10um
  medium_y = 30um
  thin_x = 1um
  thin_y = 25um
  jj_x = 1um
  jj_y = 1.9um
  L_JJ = 10nH
  wg_rad = 3mm
geometry:
  cavity [vacuum] = cylinder(axis=Z, base_centre=(0mm, 0mm, 0mm), radius=rad, height=height)
  pin [perfect conductor] = cylinder(axis=Z, base_centre=(0mm, 0mm, 0mm), radius=pin_rad, height=pin_heght)
  coordinate_system pin_end = origin=(0mm, pin_rad, pin_heght) x=(1mm, 0mm, 0mm) y=(0mm, 1mm, 0mm)
  chip [sapphire] = box(corner=(-chip_wid/2, chip_offset, -chip_thick), size=(chip_wid, chip_len, chip_thick)) in pin_end
  coordinate_system chip_begin = origin=(0mm, chip_offset, 0mm) x=(1mm, 0mm, 0mm) y=(0mm, 1mm, 0mm) in pin_end
  pads = rectangle(corner=(-pad_x/2, pad_offset, 0mm), x_size=pad_x, y_size=pad_y) in chip_begin
  coarse_lead = rectangle(corner=(-coarse_x/2, pad_offset+pad_y, 0mm), x_size=coarse_x, y_size=coarse_y) in chip_begin
  medium_lead = rectangle(corner=(-medium_x/2, pad_offset+pad_y+coarse_y, 0mm), x_size=medium_x, y_size=medium_y) in chip_begin
  thin_lead = rectangle(corner=(-thin_x/2, pad_offset+pad_y+coarse_y+medium_y, 0mm), x_size=thin_x, y_size=thin_y) in chip_begin
  coordinate_system JJ_CS = origin=(0mm, pad_offset+pad_y+coarse_y+medium_y+thin_y/2, 0mm) x=(1mm, 0mm, 0mm) y=(0mm, 1mm, 0mm) in chip_begin
  JJ = rectangle(corner=(-jj_x/2, -jj_y/2, 0mm), x_size=jj_x, y_size=jj_y) in JJ_CS
  JJ_1 = JJ.copy()
  thin_lead.subtract(JJ_1)
  left_pad_1 = pads.duplicate_mirror(point=(0mm, 0mm, 0mm), normal=(0mm, 1mm, 0mm)) in JJ_CS
  medium_lead_1 = medium_lead.duplicate_mirror(point=(0mm, 0mm, 0mm), normal=(0mm, 1mm, 0mm)) in JJ_CS
  coarse_lead_1 = coarse_lead.duplicate_mirror(point=(0mm, 0mm, 0mm), normal=(0mm, 1mm, 0mm)) in JJ_CS
  waveguide = cylinder(axis=Y, base_centre=(0mm, 0mm, 0mm), radius=wg_rad, height=chip_len) in chip_begin
  medium_lead.unite(medium_lead_1)
  coarse_lead.unite(coarse_lead_1)
  pads.unite(coarse_lead, left_pad_1)
  cavity.unite(waveguide)
  Bondwire1 [perfect conductor] = bondwire(WireType=LOW WireDiameter=0.01mm NumSides=6 XPadPos=0mm YPadPos=-1.1mm ZPadPos=0mm XDir=0mm YDir=2.15mm ZDir=0mm Distance=pad_offset+chip_offset+0.15mm h1=0.2mm h2=0mm alpha=60deg beta=60deg WhichAxis=Z) in chip_begin
boundaries and excitations:
  JJ_inductance: Lumped RLC Objects=JJ CurrentLine{(0, 6.09155, 17) -> (0, 6.09345, 17)} RLC_Type=Parallel Inductance=L_JJ Capacitance=3fF
  PerfE_Pads: Perfect E Objects=[thin_lead, pads, medium_lead]
mesh:
  JJ_mesh_0.2um: LengthBased Objects=JJ MaxLength=0.2um
  thin_lead_0.2um: LengthBased Objects=thin_lead MaxLength=0.2um
  medium_3um: LengthBased Objects=medium_lead MaxLength=3um
  pads_50um: LengthBased Objects=pads MaxLength=50um
  cav_pin1mm: LengthBased Objects=pin MaxLength=1mm
  initial mesh: GlobalCurvilinear{Apply} MeshMethod=AnsoftClassic
setups:
  Setup1: HfssEigen MinimumFrequency=1GHz NumModes=3 MaxDeltaFreq=10 ConvergeOnRealFreq=true MaximumPasses=4 MinimumPasses=3 MinimumConvergedPasses=1 PercentRefinement=30 BasisOrder=-1
source amplitudes:
  #-10:1: 0 0deg
  #-10:2: 1 0deg
  #-10:3: 0V_per_meter 0deg
optimetrics:
  ParametricSetup1: Parametric Sim._Setups=[Setup1]
    sweep L_JJ: LIN 2nH 20nH 2nH
field plots:
  Mesh2: MeshPlots in cavity on Setup1 : LastAdaptive at Phase=0deg
reports:
  Eigen Modes Plot 1: re(Mode(1)), re(Mode(2)) vs L_JJ on Setup1 : LastAdaptive; markers m1 at 10.917933nH, m2 at 10.917933nH

design no_non_model1 (HFSS, Eigenmode, model units mm)
options: Allow_Material_Override
variables:
  rad = 4mm
  height = 35mm
  pin_rad = 1.5mm
  pin_heght = 17mm
  chip_offset = 1mm
  chip_wid = 4mm
  chip_len = 20mm
  chip_thick = 0.43mm
  pad_x = 1mm
  pad_y = 0.5mm
  pad_offset = 3mm
  coarse_x = 30um
  coarse_y = 50um
  medium_x = 10um
  medium_y = 30um
  thin_x = 1um
  thin_y = 25um
  jj_x = 1um
  jj_y = 1.9um
  L_JJ = 10nH
  wg_rad = 3mm
geometry:
  cavity [vacuum] = cylinder(axis=Z, base_centre=(0mm, 0mm, 0mm), radius=rad, height=height)
  pin [perfect conductor] = cylinder(axis=Z, base_centre=(0mm, 0mm, 0mm), radius=pin_rad, height=pin_heght)
  coordinate_system pin_end = origin=(0mm, pin_rad, pin_heght) x=(1mm, 0mm, 0mm) y=(0mm, 1mm, 0mm)
  chip [sapphire] = box(corner=(-chip_wid/2, chip_offset, -chip_thick), size=(chip_wid, chip_len, chip_thick)) in pin_end
  coordinate_system chip_begin = origin=(0mm, chip_offset, 0mm) x=(1mm, 0mm, 0mm) y=(0mm, 1mm, 0mm) in pin_end
  coordinate_system JJ_CS = origin=(0mm, pad_offset+pad_y+coarse_y+medium_y+thin_y/2, 0mm) x=(1mm, 0mm, 0mm) y=(0mm, 1mm, 0mm) in chip_begin
  JJ = rectangle(corner=(-jj_x/2, -jj_y/2, 0mm), x_size=jj_x, y_size=jj_y) in JJ_CS
  waveguide = cylinder(axis=Y, base_centre=(0mm, 0mm, 0mm), radius=wg_rad, height=chip_len) in chip_begin
  cavity.unite(waveguide)
  Rectangle1 = rectangle(corner=(0.005mm, 8mm, 0mm), x_size=0.1mm, y_size=12mm) in pin_end
boundaries and excitations:
  JJ_inductance: Lumped RLC Objects=JJ CurrentLine{(0, 6.09155, 17) -> (0, 6.09345, 17)} RLC_Type=Parallel Inductance=L_JJ Capacitance=3fF
  PerfE1: Perfect E Objects=Rectangle1
mesh:
  JJ_mesh_0.2um: LengthBased Objects=JJ MaxLength=0.2um
  cav_pin1mm: LengthBased Objects=pin MaxLength=1mm
  initial mesh: GlobalCurvilinear{Apply} MeshMethod=AnsoftClassic
setups:
  Setup1: HfssEigen MinimumFrequency=1GHz NumModes=3 MaxDeltaFreq=10 ConvergeOnRealFreq=true MaximumPasses=4 MinimumPasses=3 MinimumConvergedPasses=1 PercentRefinement=30 BasisOrder=-1
source amplitudes:
  #-10:1: 1 0deg
  #-10:2: 0 0deg
  #-10:3: 0V_per_meter 0deg
optimetrics:
  ParametricSetup1: Parametric Sim._Setups=[Setup1]
    sweep L_JJ: LIN 2nH 20nH 2nH
field plots:
  Mesh2: MeshPlots in cavity on Setup1 : LastAdaptive at Phase=0deg
  Mag_E1: E Field in cavity on Setup1 : LastAdaptive at Phase=0deg

design no_non_model2 (HFSS, Eigenmode, model units mm)
options: Allow_Material_Override
variables:
  rad = 4mm
  height = 35mm
  pin_rad = 1.5mm
  pin_heght = 17mm
  chip_offset = 1mm
  chip_wid = 4mm
  chip_len = 20mm
  chip_thick = 0.43mm
  pad_x = 1mm
  pad_y = 0.5mm
  pad_offset = 3mm
  coarse_x = 30um
  coarse_y = 50um
  medium_x = 10um
  medium_y = 30um
  thin_x = 1um
  thin_y = 25um
  jj_x = 1um
  jj_y = 1.9um
  L_JJ = 10nH
  wg_rad = 3mm
geometry:
  cavity [vacuum] = cylinder(axis=Z, base_centre=(0mm, 0mm, 0mm), radius=rad, height=height)
  pin [perfect conductor] = cylinder(axis=Z, base_centre=(0mm, 0mm, 0mm), radius=pin_rad, height=pin_heght)
  coordinate_system pin_end = origin=(0mm, pin_rad, pin_heght) x=(1mm, 0mm, 0mm) y=(0mm, 1mm, 0mm)
  chip [sapphire] = box(corner=(-chip_wid/2, chip_offset, -chip_thick), size=(chip_wid, chip_len, chip_thick)) in pin_end
  coordinate_system chip_begin = origin=(0mm, chip_offset, 0mm) x=(1mm, 0mm, 0mm) y=(0mm, 1mm, 0mm) in pin_end
  pads = rectangle(corner=(-pad_x/2, pad_offset, 0mm), x_size=pad_x, y_size=pad_y) in chip_begin
  coarse_lead = rectangle(corner=(-coarse_x/2, pad_offset+pad_y, 0mm), x_size=coarse_x, y_size=coarse_y) in chip_begin
  medium_lead = rectangle(corner=(-medium_x/2, pad_offset+pad_y+coarse_y, 0mm), x_size=medium_x, y_size=medium_y) in chip_begin
  thin_lead = rectangle(corner=(-thin_x/2, pad_offset+pad_y+coarse_y+medium_y, 0mm), x_size=thin_x, y_size=thin_y) in chip_begin
  coordinate_system JJ_CS = origin=(0mm, pad_offset+pad_y+coarse_y+medium_y+thin_y/2, 0mm) x=(1mm, 0mm, 0mm) y=(0mm, 1mm, 0mm) in chip_begin
  JJ = rectangle(corner=(-jj_x/2, -jj_y/2, 0mm), x_size=jj_x, y_size=jj_y) in JJ_CS
  JJ_1 = JJ.copy()
  thin_lead.subtract(JJ_1)
  left_pad_1 = pads.duplicate_mirror(point=(0mm, 0mm, 0mm), normal=(0mm, 1mm, 0mm)) in JJ_CS
  medium_lead_1 = medium_lead.duplicate_mirror(point=(0mm, 0mm, 0mm), normal=(0mm, 1mm, 0mm)) in JJ_CS
  coarse_lead_1 = coarse_lead.duplicate_mirror(point=(0mm, 0mm, 0mm), normal=(0mm, 1mm, 0mm)) in JJ_CS
  waveguide = cylinder(axis=Y, base_centre=(0mm, 0mm, 0mm), radius=wg_rad, height=chip_len) in chip_begin
  medium_lead.unite(medium_lead_1)
  coarse_lead.unite(coarse_lead_1)
  pads.unite(coarse_lead, left_pad_1)
  cavity.unite(waveguide)
boundaries and excitations:
  JJ_inductance: Lumped RLC Objects=JJ CurrentLine{(0, 6.09155, 17) -> (0, 6.09345, 17)} RLC_Type=Parallel Inductance=L_JJ Capacitance=3fF
  PerfE_Pads: Perfect E Objects=[thin_lead, pads, medium_lead]
mesh:
  JJ_mesh_0.2um: LengthBased Objects=JJ MaxLength=0.2um
  thin_lead_0.2um: LengthBased Objects=thin_lead MaxLength=0.2um
  medium_3um: LengthBased Objects=medium_lead MaxLength=3um
  pads_50um: LengthBased Objects=pads MaxLength=50um
  cav_pin1mm: LengthBased Objects=pin MaxLength=1mm
  initial mesh: GlobalCurvilinear{Apply} MeshMethod=AnsoftClassic
setups:
  Setup1: HfssEigen MinimumFrequency=1GHz NumModes=3 MaxDeltaFreq=10 ConvergeOnRealFreq=true MaximumPasses=4 MinimumPasses=3 MinimumConvergedPasses=1 PercentRefinement=30 BasisOrder=-1
source amplitudes:
  #-10:1: 0 0deg
  #-10:2: 1 0deg
  #-10:3: 0V_per_meter 0deg
optimetrics:
  ParametricSetup1: Parametric Sim._Setups=[Setup1]
    sweep L_JJ: LIN 2nH 20nH 2nH
field plots:
  Mesh2: MeshPlots in cavity on Setup1 : LastAdaptive at Phase=0deg
reports:
  Eigen Modes Plot 1: re(Mode(1)), re(Mode(2)) vs L_JJ on Setup1 : LastAdaptive; markers m1 at 10.917933nH, m2 at 10.917933nH

design galvanic_one_loss_added (HFSS, Eigenmode, model units mm)
options: Allow_Material_Override
variables:
  rad = 4mm
  height = 35mm
  pin_rad = 1.5mm
  pin_heght = 17mm
  chip_offset = 1mm
  chip_wid = 4mm
  chip_len = 20mm
  chip_thick = 0.43mm
  pad_x = 1mm
  pad_y = 0.5mm
  pad_offset = 3mm
  coarse_x = 30um
  coarse_y = 50um
  medium_x = 10um
  medium_y = 30um
  thin_x = 1um
  thin_y = 25um
  jj_x = 1um
  jj_y = 1.9um
  L_JJ = 10nH
  wg_rad = 3mm
  rr_x = 0.3mm
  rr_y = 8mm
geometry:
  cavity [vacuum] = cylinder(axis=Z, base_centre=(0mm, 0mm, 0mm), radius=rad, height=height)
  pin [perfect conductor] = cylinder(axis=Z, base_centre=(0mm, 0mm, 0mm), radius=pin_rad, height=pin_heght)
  coordinate_system pin_end = origin=(0mm, pin_rad, pin_heght) x=(1mm, 0mm, 0mm) y=(0mm, 1mm, 0mm)
  chip [sapphire] = box(corner=(-chip_wid/2, chip_offset, -chip_thick), size=(chip_wid, chip_len, chip_thick)) in pin_end
  coordinate_system chip_begin = origin=(0mm, chip_offset, 0mm) x=(1mm, 0mm, 0mm) y=(0mm, 1mm, 0mm) in pin_end
  pads = rectangle(corner=(-pad_x/2, pad_offset, 0mm), x_size=pad_x, y_size=pad_y) in chip_begin
  coarse_lead = rectangle(corner=(-coarse_x/2, pad_offset+pad_y, 0mm), x_size=coarse_x, y_size=coarse_y) in chip_begin
  medium_lead = rectangle(corner=(-medium_x/2, pad_offset+pad_y+coarse_y, 0mm), x_size=medium_x, y_size=medium_y) in chip_begin
  thin_lead = rectangle(corner=(-thin_x/2, pad_offset+pad_y+coarse_y+medium_y, 0mm), x_size=thin_x, y_size=thin_y) in chip_begin
  coordinate_system JJ_CS = origin=(0mm, pad_offset+pad_y+coarse_y+medium_y+thin_y/2, 0mm) x=(1mm, 0mm, 0mm) y=(0mm, 1mm, 0mm) in chip_begin
  JJ = rectangle(corner=(-jj_x/2, -jj_y/2, 0mm), x_size=jj_x, y_size=jj_y) in JJ_CS
  JJ_1 = JJ.copy()
  thin_lead.subtract(JJ_1)
  left_pad_1 = pads.duplicate_mirror(point=(0mm, 0mm, 0mm), normal=(0mm, 1mm, 0mm)) in JJ_CS
  medium_lead_1 = medium_lead.duplicate_mirror(point=(0mm, 0mm, 0mm), normal=(0mm, 1mm, 0mm)) in JJ_CS
  coarse_lead_1 = coarse_lead.duplicate_mirror(point=(0mm, 0mm, 0mm), normal=(0mm, 1mm, 0mm)) in JJ_CS
  waveguide = cylinder(axis=Y, base_centre=(0mm, 0mm, 0mm), radius=wg_rad, height=chip_len) in chip_begin
  medium_lead.unite(medium_lead_1)
  coarse_lead.unite(coarse_lead_1)
  pads.unite(coarse_lead, left_pad_1)
  cavity.unite(waveguide)
  Plot_Fields2D [vacuum, non-model] = box(corner=(5mm, -10mm, 0mm), size=(-10mm, 30mm, 0mm)) in chip_begin
  Bondwire1 [perfect conductor] = bondwire(WireType=LOW WireDiameter=0.01mm NumSides=6 XPadPos=0mm YPadPos=-1.1mm ZPadPos=0mm XDir=0mm YDir=2.15mm ZDir=0mm Distance=pad_offset+chip_offset+0.15mm h1=0.2mm h2=0mm alpha=60deg beta=60deg WhichAxis=Z) in chip_begin
  Plot_Fields3D [vacuum, non-model] = box(corner=(5mm, -10mm, -5mm), size=(-10mm, 30mm, 10mm)) in chip_begin
  Rectangle1 = rectangle(corner=(-rr_x/2, 1mm, 0mm), x_size=rr_x, y_size=rr_y) in JJ_CS
boundaries and excitations:
  JJ_inductance: Lumped RLC Objects=JJ CurrentLine{(0, 6.09155, 17) -> (0, 6.09345, 17)} RLC_Type=Parallel Inductance=L_JJ Capacitance=3fF
  PerfE_Pads: Perfect E Objects=[thin_lead, pads, medium_lead]
  PerfE_RR: Perfect E Objects=Rectangle1
mesh:
  JJ_mesh_0.2um: LengthBased Objects=JJ MaxLength=0.2um
  thin_lead_0.2um: LengthBased Objects=thin_lead MaxLength=0.2um
  medium_3um: LengthBased Objects=medium_lead MaxLength=3um
  pads_50um: LengthBased Objects=pads MaxLength=50um
  cav_pin1mm: LengthBased Objects=pin MaxLength=1mm
  initial mesh: GlobalCurvilinear{Apply} MeshMethod=AnsoftClassic
setups:
  Setup1: HfssEigen MinimumFrequency=1GHz NumModes=3 MaxDeltaFreq=10 ConvergeOnRealFreq=true MaximumPasses=4 MinimumPasses=3 MinimumConvergedPasses=1 PercentRefinement=30 BasisOrder=-1
source amplitudes:
  #-10:1: 0 0deg
  #-10:2: 1 0deg
  #-10:3: 0V_per_meter 0deg
optimetrics:
  ParametricSetup1: Parametric Sim._Setups=[Setup1]
    sweep L_JJ: LIN 2nH 20nH 2nH
field plots:
  Mag_E1: E Field in Plot_Fields3D on Setup1 : LastAdaptive at Phase=0deg
  Mesh1: MeshPlots over a plane on Setup1 : LastAdaptive at Phase=0deg
  Mesh2: MeshPlots in cavity on Setup1 : LastAdaptive at Phase=0deg
reports:
  Eigen Modes Plot 1: re(Mode(1)), re(Mode(2)) vs L_JJ on Setup1 : LastAdaptive; markers m1 at 10.917933nH, m2 at 10.917933nH

design galvanic_one_loss_added_no_non_model (HFSS, Eigenmode, model units mm)
options: Allow_Material_Override
variables:
  rad = 4mm
  height = 35mm
  pin_rad = 1.5mm
  pin_heght = 17mm
  chip_offset = 1mm
  chip_wid = 4mm
  chip_len = 20mm
  chip_thick = 0.43mm
  pad_x = 1mm
  pad_y = 0.5mm
  pad_offset = 3mm
  coarse_x = 30um
  coarse_y = 50um
  medium_x = 10um
  medium_y = 30um
  thin_x = 1um
  thin_y = 25um
  jj_x = 1um
  jj_y = 1.9um
  L_JJ = 10nH
  wg_rad = 3mm
  rr_x = 0.3mm
  rr_y = 8mm
geometry:
  cavity [vacuum] = cylinder(axis=Z, base_centre=(0mm, 0mm, 0mm), radius=rad, height=height)
  pin [perfect conductor] = cylinder(axis=Z, base_centre=(0mm, 0mm, 0mm), radius=pin_rad, height=pin_heght)
  coordinate_system pin_end = origin=(0mm, pin_rad, pin_heght) x=(1mm, 0mm, 0mm) y=(0mm, 1mm, 0mm)
  chip [sapphire] = box(corner=(-chip_wid/2, chip_offset, -chip_thick), size=(chip_wid, chip_len, chip_thick)) in pin_end
  coordinate_system chip_begin = origin=(0mm, chip_offset, 0mm) x=(1mm, 0mm, 0mm) y=(0mm, 1mm, 0mm) in pin_end
  pads = rectangle(corner=(-pad_x/2, pad_offset, 0mm), x_size=pad_x, y_size=pad_y) in chip_begin
  coarse_lead = rectangle(corner=(-coarse_x/2, pad_offset+pad_y, 0mm), x_size=coarse_x, y_size=coarse_y) in chip_begin
  medium_lead = rectangle(corner=(-medium_x/2, pad_offset+pad_y+coarse_y, 0mm), x_size=medium_x, y_size=medium_y) in chip_begin
  thin_lead = rectangle(corner=(-thin_x/2, pad_offset+pad_y+coarse_y+medium_y, 0mm), x_size=thin_x, y_size=thin_y) in chip_begin
  coordinate_system JJ_CS = origin=(0mm, pad_offset+pad_y+coarse_y+medium_y+thin_y/2, 0mm) x=(1mm, 0mm, 0mm) y=(0mm, 1mm, 0mm) in chip_begin
  JJ = rectangle(corner=(-jj_x/2, -jj_y/2, 0mm), x_size=jj_x, y_size=jj_y) in JJ_CS
  JJ_1 = JJ.copy()
  thin_lead.subtract(JJ_1)
  left_pad_1 = pads.duplicate_mirror(point=(0mm, 0mm, 0mm), normal=(0mm, 1mm, 0mm)) in JJ_CS
  medium_lead_1 = medium_lead.duplicate_mirror(point=(0mm, 0mm, 0mm), normal=(0mm, 1mm, 0mm)) in JJ_CS
  coarse_lead_1 = coarse_lead.duplicate_mirror(point=(0mm, 0mm, 0mm), normal=(0mm, 1mm, 0mm)) in JJ_CS
  waveguide = cylinder(axis=Y, base_centre=(0mm, 0mm, 0mm), radius=wg_rad, height=chip_len) in chip_begin
  medium_lead.unite(medium_lead_1)
  coarse_lead.unite(coarse_lead_1)
  pads.unite(coarse_lead, left_pad_1)
  cavity.unite(waveguide)
  Bondwire1 [perfect conductor] = bondwire(WireType=LOW WireDiameter=0.01mm NumSides=6 XPadPos=0mm YPadPos=-1.1mm ZPadPos=0mm XDir=0mm YDir=2.15mm ZDir=0mm Distance=pad_offset+chip_offset+0.15mm h1=0.2mm h2=0mm alpha=60deg beta=60deg WhichAxis=Z) in chip_begin
  RR = rectangle(corner=(-rr_x/2, 1mm, 0mm), x_size=rr_x, y_size=rr_y) in JJ_CS
boundaries and excitations:
  JJ_inductance: Lumped RLC Objects=JJ CurrentLine{(0, 6.09155, 17) -> (0, 6.09345, 17)} RLC_Type=Parallel Inductance=L_JJ Capacitance=3fF
  PerfE_Pads: Perfect E Objects=[thin_lead, pads, medium_lead]
  PerfE_RR: Perfect E Objects=RR
mesh:
  JJ_mesh_0.2um: LengthBased Objects=JJ MaxLength=0.2um
  thin_lead_0.2um: LengthBased Objects=thin_lead MaxLength=0.2um
  medium_3um: LengthBased Objects=medium_lead MaxLength=3um
  pads_50um: LengthBased Objects=pads MaxLength=50um
  cav_pin1mm: LengthBased Objects=pin MaxLength=1mm
  RR_mesh_0.05mm: LengthBased Objects=RR MaxLength=0.05mm
  initial mesh: GlobalCurvilinear{Apply} MeshMethod=AnsoftClassic
setups:
  Setup1: HfssEigen MinimumFrequency=1GHz NumModes=3 MaxDeltaFreq=2 ConvergeOnRealFreq=true MaximumPasses=5 MinimumPasses=3 MinimumConvergedPasses=2 PercentRefinement=30 BasisOrder=-1
source amplitudes:
  #-10:1: 0 0deg
  #-10:2: 1 0deg
  #-10:3: 0V_per_meter 0deg
optimetrics:
  ParametricSetup1: Parametric Sim._Setups=[Setup1]
    sweep L_JJ: LIN 2nH 20nH 2nH
field plots:
  Mesh2: MeshPlots in cavity on Setup1 : LastAdaptive at Phase=0deg
  Mesh1, Mesh3, Mesh4: MeshPlots over RR.face on Setup1 : LastAdaptive at Phase=0deg
reports:
  Eigen Modes Plot 1: re(Mode(1)), re(Mode(2)) vs L_JJ on Setup1 : LastAdaptive; markers m1 at 10.917933nH, m2 at 10.917933nH

design galvanic_one_rr_pin (HFSS, Eigenmode, model units mm)
options: Allow_Material_Override
variables:
  rad = 4mm
  height = 35mm
  pin_rad = 1.5mm
  pin_heght = 17mm
  chip_offset = 1mm
  chip_wid = 4mm
  chip_len = 20mm
  chip_thick = 0.43mm
  pad_x = 1mm
  pad_y = 0.5mm
  pad_offset = 3mm
  coarse_x = 30um
  coarse_y = 50um
  medium_x = 10um
  medium_y = 30um
  thin_x = 1um
  thin_y = 25um
  jj_x = 1um
  jj_y = 1.9um
  L_JJ = 10nH
  wg_rad = 3mm
  rr_x = 0.3mm
  rr_y = 8mm
  rr_offset = 0.5mm
  pin_offset = 3mm
  pin_height = 7mm
  pin_z = 1.5mm
geometry:
  cavity [vacuum] = cylinder(axis=Z, base_centre=(0mm, 0mm, 0mm), radius=rad, height=height)
  pin [perfect conductor] = cylinder(axis=Z, base_centre=(0mm, 0mm, 0mm), radius=pin_rad, height=pin_heght)
  coordinate_system pin_end = origin=(0mm, pin_rad, pin_heght) x=(1mm, 0mm, 0mm) y=(0mm, 1mm, 0mm)
  chip [sapphire] = box(corner=(-chip_wid/2, chip_offset, -chip_thick), size=(chip_wid, chip_len, chip_thick)) in pin_end
  coordinate_system chip_begin = origin=(0mm, chip_offset, 0mm) x=(1mm, 0mm, 0mm) y=(0mm, 1mm, 0mm) in pin_end
  pads = rectangle(corner=(-pad_x/2, pad_offset, 0mm), x_size=pad_x, y_size=pad_y) in chip_begin
  coarse_lead = rectangle(corner=(-coarse_x/2, pad_offset+pad_y, 0mm), x_size=coarse_x, y_size=coarse_y) in chip_begin
  medium_lead = rectangle(corner=(-medium_x/2, pad_offset+pad_y+coarse_y, 0mm), x_size=medium_x, y_size=medium_y) in chip_begin
  thin_lead = rectangle(corner=(-thin_x/2, pad_offset+pad_y+coarse_y+medium_y, 0mm), x_size=thin_x, y_size=thin_y) in chip_begin
  coordinate_system JJ_CS = origin=(0mm, pad_offset+pad_y+coarse_y+medium_y+thin_y/2, 0mm) x=(1mm, 0mm, 0mm) y=(0mm, 1mm, 0mm) in chip_begin
  JJ = rectangle(corner=(-jj_x/2, -jj_y/2, 0mm), x_size=jj_x, y_size=jj_y) in JJ_CS
  JJ_1 = JJ.copy()
  thin_lead.subtract(JJ_1)
  left_pad_1 = pads.duplicate_mirror(point=(0mm, 0mm, 0mm), normal=(0mm, 1mm, 0mm)) in JJ_CS
  medium_lead_1 = medium_lead.duplicate_mirror(point=(0mm, 0mm, 0mm), normal=(0mm, 1mm, 0mm)) in JJ_CS
  coarse_lead_1 = coarse_lead.duplicate_mirror(point=(0mm, 0mm, 0mm), normal=(0mm, 1mm, 0mm)) in JJ_CS
  waveguide = cylinder(axis=Y, base_centre=(0mm, 0mm, 0mm), radius=wg_rad, height=chip_len) in chip_begin
  medium_lead.unite(medium_lead_1)
  coarse_lead.unite(coarse_lead_1)
  pads.unite(coarse_lead, left_pad_1)
  cavity.unite(waveguide)
  Bondwire1 [perfect conductor] = bondwire(WireType=LOW WireDiameter=0.01mm NumSides=6 XPadPos=0mm YPadPos=-1.1mm ZPadPos=0mm XDir=0mm YDir=2.15mm ZDir=0mm Distance=pad_offset+chip_offset+0.15mm h1=0.2mm h2=0mm alpha=60deg beta=60deg WhichAxis=Z) in chip_begin
  coordinate_system RR_CS = origin=(0mm, pad_offset+2*(pad_y+coarse_y+medium_y)+thin_y+rr_offset, 0mm) x=(1mm, 0mm, 0mm) y=(0mm, 1mm, 0mm) in chip_begin
  RR = rectangle(corner=(-rr_x/2, 0, 0mm), x_size=rr_x, y_size=rr_y) in RR_CS
  Pin_1 [copper] = cylinder(axis=Z, base_centre=(0mm, pin_offset, pin_z), radius=0.5mm, height=pin_height) in RR_CS
  Pin_wg = cylinder(axis=Z, base_centre=(0mm, pin_offset, pin_z), radius=1mm, height=pin_height) in RR_CS
  cavity.unite(Pin_wg)
boundaries and excitations:
  JJ_inductance: Lumped RLC Objects=JJ CurrentLine{(0, 6.09155, 17) -> (0, 6.09345, 17)} RLC_Type=Parallel Inductance=L_JJ Capacitance=3fF
  PerfE_Pads: Perfect E Objects=[thin_lead, pads, medium_lead]
  PerfE_RR: Perfect E Objects=RR
  Imped_pin: Impedance Faces=cavity.face(at (0, 10.185, 25.5)) Resistance=50 Reactance=0
mesh:
  JJ_mesh_0.2um: LengthBased Objects=JJ MaxLength=0.2um
  thin_lead_0.2um: LengthBased Objects=thin_lead MaxLength=0.2um
  medium_3um: LengthBased Objects=medium_lead MaxLength=3um
  pads_50um: LengthBased Objects=pads MaxLength=50um
  cav_pin1mm: LengthBased Objects=pin MaxLength=1mm
  RR_mesh_0.05mm: LengthBased Objects=RR MaxLength=0.05mm
  initial mesh: GlobalCurvilinear{Apply} MeshMethod=AnsoftClassic
setups:
  Setup1: HfssEigen MinimumFrequency=1GHz NumModes=3 MaxDeltaFreq=2 ConvergeOnRealFreq=true MaximumPasses=5 MinimumPasses=3 MinimumConvergedPasses=2 PercentRefinement=30 BasisOrder=-1
  Setup2: HfssEigen MinimumFrequency=2GHz NumModes=5 MaxDeltaFreq=10 ConvergeOnRealFreq=true MaximumPasses=3 MinimumPasses=1 MinimumConvergedPasses=1 PercentRefinement=30 BasisOrder=-1
source amplitudes:
  #-10:1: 0 0deg
  #-10:2: 1 0deg
  #-10:3, #-10:4, #-10:5: 0V_per_meter 0deg
optimetrics:
  ParametricSetup1: Parametric Sim._Setups=[Setup1]
    sweep L_JJ: LIN 2nH 20nH 2nH
field plots:
  Mesh2: MeshPlots in cavity on Setup1 : LastAdaptive at Phase=0deg
  Mesh1, Mesh3, Mesh4: MeshPlots over RR.face on Setup1 : LastAdaptive at Phase=0deg
  Mag_E1: E Field in cavity on Setup1 : LastAdaptive at Phase=0deg
  Mag_E2: E Field in cavity on Setup2 : LastAdaptive at Phase=0deg
reports:
  Eigen Modes Plot 1: re(Mode(1)), re(Mode(2)) vs L_JJ on Setup1 : LastAdaptive; markers m1 at 10.917933nH, m2 at 10.917933nH

design galvanic_one_rr_pin_no_wirebond (HFSS, Eigenmode, model units mm)
options: Allow_Material_Override
variables:
  rad = 4mm
  height = 35mm
  pin_rad = 1.5mm
  pin_heght = 17mm
  chip_offset = 1mm
  chip_wid = 4mm
  chip_len = 20mm
  chip_thick = 0.43mm
  pad_x = 1mm
  pad_y = 0.5mm
  pad_offset = 3mm
  coarse_x = 30um
  coarse_y = 50um
  medium_x = 10um
  medium_y = 30um
  thin_x = 1um
  thin_y = 25um
  jj_x = 1um
  jj_y = 1.9um
  L_JJ = 10nH
  wg_rad = 3mm
  rr_x = 0.3mm
  rr_y = 8mm
  rr_offset = 0.5mm
  pin_offset = 3mm
  pin_height = 7mm
  pin_z = 1.5mm
geometry:
  cavity [vacuum] = cylinder(axis=Z, base_centre=(0mm, 0mm, 0mm), radius=rad, height=height)
  pin [perfect conductor] = cylinder(axis=Z, base_centre=(0mm, 0mm, 0mm), radius=pin_rad, height=pin_heght)
  coordinate_system pin_end = origin=(0mm, pin_rad, pin_heght) x=(1mm, 0mm, 0mm) y=(0mm, 1mm, 0mm)
  chip [sapphire] = box(corner=(-chip_wid/2, chip_offset, -chip_thick), size=(chip_wid, chip_len, chip_thick)) in pin_end
  coordinate_system chip_begin = origin=(0mm, chip_offset, 0mm) x=(1mm, 0mm, 0mm) y=(0mm, 1mm, 0mm) in pin_end
  pads = rectangle(corner=(-pad_x/2, pad_offset, 0mm), x_size=pad_x, y_size=pad_y) in chip_begin
  coarse_lead = rectangle(corner=(-coarse_x/2, pad_offset+pad_y, 0mm), x_size=coarse_x, y_size=coarse_y) in chip_begin
  medium_lead = rectangle(corner=(-medium_x/2, pad_offset+pad_y+coarse_y, 0mm), x_size=medium_x, y_size=medium_y) in chip_begin
  thin_lead = rectangle(corner=(-thin_x/2, pad_offset+pad_y+coarse_y+medium_y, 0mm), x_size=thin_x, y_size=thin_y) in chip_begin
  coordinate_system JJ_CS = origin=(0mm, pad_offset+pad_y+coarse_y+medium_y+thin_y/2, 0mm) x=(1mm, 0mm, 0mm) y=(0mm, 1mm, 0mm) in chip_begin
  JJ = rectangle(corner=(-jj_x/2, -jj_y/2, 0mm), x_size=jj_x, y_size=jj_y) in JJ_CS
  JJ_1 = JJ.copy()
  thin_lead.subtract(JJ_1)
  left_pad_1 = pads.duplicate_mirror(point=(0mm, 0mm, 0mm), normal=(0mm, 1mm, 0mm)) in JJ_CS
  medium_lead_1 = medium_lead.duplicate_mirror(point=(0mm, 0mm, 0mm), normal=(0mm, 1mm, 0mm)) in JJ_CS
  coarse_lead_1 = coarse_lead.duplicate_mirror(point=(0mm, 0mm, 0mm), normal=(0mm, 1mm, 0mm)) in JJ_CS
  waveguide = cylinder(axis=Y, base_centre=(0mm, 0mm, 0mm), radius=wg_rad, height=chip_len) in chip_begin
  medium_lead.unite(medium_lead_1)
  coarse_lead.unite(coarse_lead_1)
  pads.unite(coarse_lead, left_pad_1)
  cavity.unite(waveguide)
  coordinate_system RR_CS = origin=(0mm, pad_offset+2*(pad_y+coarse_y+medium_y)+thin_y+rr_offset, 0mm) x=(1mm, 0mm, 0mm) y=(0mm, 1mm, 0mm) in chip_begin
  RR = rectangle(corner=(-rr_x/2, 0, 0mm), x_size=rr_x, y_size=rr_y) in RR_CS
  Pin_1 [copper] = cylinder(axis=Z, base_centre=(0mm, pin_offset, pin_z), radius=0.5mm, height=pin_height) in RR_CS
  Pin_wg = cylinder(axis=Z, base_centre=(0mm, pin_offset, pin_z), radius=1mm, height=pin_height) in RR_CS
  cavity.unite(Pin_wg)
  line_JJ [non-model] = polyline((0mm, -jj_y/2, 0mm) (0mm, jj_y/2, 0mm)) in JJ_CS
boundaries and excitations:
  JJ_inductance: Lumped RLC Objects=JJ CurrentLine{(0, 6.09155, 17) -> (0, 6.09345, 17)} RLC_Type=Parallel Inductance=L_JJ Capacitance=3fF
  PerfE_Pads: Perfect E Objects=[thin_lead, pads, medium_lead]
  PerfE_RR: Perfect E Objects=RR
  Imped_pin: Impedance Faces=cavity.face(at (0, 10.185, 25.5)) Resistance=50 Reactance=0
mesh:
  JJ_mesh_0.2um: LengthBased Objects=JJ MaxLength=0.2um
  thin_lead_0.2um: LengthBased Objects=thin_lead MaxLength=0.2um
  medium_3um: LengthBased Objects=medium_lead MaxLength=3um
  pads_50um: LengthBased Objects=pads MaxLength=50um
  cav_pin1mm: LengthBased Objects=pin MaxLength=1mm
  RR_mesh_0.05mm: LengthBased Objects=RR MaxLength=0.05mm
  initial mesh: GlobalCurvilinear{Apply} MeshMethod=AnsoftClassic
setups:
  Setup1: HfssEigen MinimumFrequency=1GHz NumModes=3 MaxDeltaFreq=2 ConvergeOnRealFreq=true MaximumPasses=5 MinimumPasses=3 MinimumConvergedPasses=2 PercentRefinement=30 BasisOrder=-1
  Setup2: HfssEigen MinimumFrequency=2GHz NumModes=5 MaxDeltaFreq=10 ConvergeOnRealFreq=true MaximumPasses=3 MinimumPasses=1 MinimumConvergedPasses=1 PercentRefinement=30 BasisOrder=-1
source amplitudes:
  #-10:1: 1 0deg
  #-10:2: 0 0deg
  #-10:3, #-10:4, #-10:5: 0V_per_meter 0deg
optimetrics:
  ParametricSetup1: Parametric Sim._Setups=[Setup1]
    sweep L_JJ: LIN 2nH 20nH 2nH
field plots:
  Mesh2: MeshPlots in cavity on Setup1 : LastAdaptive at Phase=0deg
  Mesh1, Mesh3, Mesh4: MeshPlots over RR.face on Setup1 : LastAdaptive at Phase=0deg
  Mag_E1: E Field in cavity on Setup1 : LastAdaptive at Phase=0deg
  Mag_E2, Mag_E3: E Field in cavity on Setup2 : LastAdaptive at Phase=0deg
reports:
  Eigen Modes Plot 1: re(Mode(1)), re(Mode(2)) vs L_JJ on Setup1 : LastAdaptive; markers m1 at 10.917933nH, m2 at 10.917933nH
